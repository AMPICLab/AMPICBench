* sim_Opamp_2stg_FC_ClassA_STB: subcircuits with parameters evaluated (W/L in um, sky130A models)
* generated by tools/import_cadence.py from sim_Opamp_2stg_FC_ClassA_STB.cir
.subckt Bias_gen Vbiasn Vbiasp
  XNM0 Vbiasn Vbiasn 0 0 sky130_fd_pr__nfet_01v8_lvt W=5 L=0.3 nf=1 m=1 as=1.325 ad=1.325 ps=10.53 pd=10.53
  II1 Vbiasp 0 dc 2e-05
  II0 vdd Vbiasn dc 2e-05
  XPM0 Vbiasp Vbiasp vdd vdd sky130_fd_pr__pfet_01v8_lvt W=20 L=0.7 nf=1 m=1 as=5.3 ad=5.3 ps=40.53 pd=40.53
.ends Bias_gen
.subckt Cascode_bias Vbias_1 Vbias_2 Vbias_3 Vbias_4 Vbiasp
  XNM11 net4 net4 Vbias_4 0 sky130_fd_pr__nfet_01v8_lvt W=5 L=0.3 nf=1 m=1 as=1.325 ad=1.325 ps=10.53 pd=10.53
  XNM9 net2 net2 Vbias_3 0 sky130_fd_pr__nfet_01v8_lvt W=5 L=0.3 nf=1 m=1 as=1.325 ad=1.325 ps=10.53 pd=10.53
  XNM0 Vbias_3 Vbias_3 0 0 sky130_fd_pr__nfet_01v8_lvt W=5 L=3.8 nf=1 m=1 as=1.325 ad=1.325 ps=10.53 pd=10.53
  XNM6 net6 Vbias_4 0 0 sky130_fd_pr__nfet_01v8_lvt W=5 L=0.3 nf=1 m=1 as=1.325 ad=1.325 ps=10.53 pd=10.53
  XNM4 net3 Vbias_4 0 0 sky130_fd_pr__nfet_01v8_lvt W=5 L=0.3 nf=1 m=1 as=1.325 ad=1.325 ps=10.53 pd=10.53
  XNM2 net1 Vbias_4 0 0 sky130_fd_pr__nfet_01v8_lvt W=5 L=0.3 nf=1 m=1 as=1.325 ad=1.325 ps=10.53 pd=10.53
  XNM5 Vbias_1 Vbias_3 net6 0 sky130_fd_pr__nfet_01v8_lvt W=5 L=0.3 nf=1 m=1 as=1.325 ad=1.325 ps=10.53 pd=10.53
  XNM3 Vbias_2 Vbias_3 net3 0 sky130_fd_pr__nfet_01v8_lvt W=5 L=0.3 nf=1 m=1 as=1.325 ad=1.325 ps=10.53 pd=10.53
  XNM1 Vbias_4 Vbias_3 net1 0 sky130_fd_pr__nfet_01v8_lvt W=5 L=0.3 nf=1 m=1 as=1.325 ad=1.325 ps=10.53 pd=10.53
  XPM4 Vbias_1 Vbias_2 net5 vdd sky130_fd_pr__pfet_01v8_lvt W=20 L=0.7 nf=1 m=1 as=5.3 ad=5.3 ps=40.53 pd=40.53
  XPM3 net5 Vbias_1 vdd vdd sky130_fd_pr__pfet_01v8_lvt W=20 L=0.7 nf=1 m=1 as=5.3 ad=5.3 ps=40.53 pd=40.53
  XPM0 net2 Vbiasp vdd vdd sky130_fd_pr__pfet_01v8_lvt W=20 L=0.7 nf=1 m=1 as=5.3 ad=5.3 ps=40.53 pd=40.53
  XPM2 Vbias_2 Vbias_2 vdd vdd sky130_fd_pr__pfet_01v8_lvt W=20 L=3.4 nf=1 m=1 as=5.3 ad=5.3 ps=40.53 pd=40.53
  XPM1 net4 Vbiasp vdd vdd sky130_fd_pr__pfet_01v8_lvt W=20 L=0.7 nf=1 m=1 as=5.3 ad=5.3 ps=40.53 pd=40.53
.ends Cascode_bias
.subckt FC_Amp Vbias_2 Vbias_3 Vbias_4 vm vout vp
  XNM5 net019 Vbias_4 0 0 sky130_fd_pr__nfet_01v8_lvt W=5 L=0.3 nf=1 m=1 as=1.325 ad=1.325 ps=10.53 pd=10.53
  XNM3 vout Vbias_3 net017 0 sky130_fd_pr__nfet_01v8_lvt W=5 L=0.3 nf=1 m=1 as=1.325 ad=1.325 ps=10.53 pd=10.53
  XNM9 net010 vp net08 0 sky130_fd_pr__nfet_01v8_lvt W=5 L=0.3 nf=1 m=1 as=1.325 ad=1.325 ps=10.53 pd=10.53
  XNM0 net08 Vbias_3 net020 0 sky130_fd_pr__nfet_01v8_lvt W=5 L=0.3 nf=1 m=1 as=1.325 ad=1.325 ps=10.53 pd=10.53
  XNM10 net016 vm net08 0 sky130_fd_pr__nfet_01v8_lvt W=5 L=0.3 nf=1 m=1 as=1.325 ad=1.325 ps=10.53 pd=10.53
  XNM4 net020 Vbias_4 0 0 sky130_fd_pr__nfet_01v8_lvt W=5 L=0.3 nf=1 m=1 as=1.325 ad=1.325 ps=10.53 pd=10.53
  XNM6 net018 Vbias_4 0 0 sky130_fd_pr__nfet_01v8_lvt W=5 L=0.3 nf=1 m=1 as=1.325 ad=1.325 ps=10.53 pd=10.53
  XNM8 net017 Vbias_4 0 0 sky130_fd_pr__nfet_01v8_lvt W=5 L=0.3 nf=1 m=1 as=1.325 ad=1.325 ps=10.53 pd=10.53
  XNM2 net013 Vbias_3 net018 0 sky130_fd_pr__nfet_01v8_lvt W=5 L=0.3 nf=1 m=1 as=1.325 ad=1.325 ps=10.53 pd=10.53
  XNM1 net08 Vbias_3 net019 0 sky130_fd_pr__nfet_01v8_lvt W=5 L=0.3 nf=1 m=1 as=1.325 ad=1.325 ps=10.53 pd=10.53
  XPM3 net010 net013 vdd vdd sky130_fd_pr__pfet_01v8_lvt W=20 L=0.7 nf=1 m=1 as=5.3 ad=5.3 ps=40.53 pd=40.53
  XPM2 net010 net013 vdd vdd sky130_fd_pr__pfet_01v8_lvt W=20 L=0.7 nf=1 m=1 as=5.3 ad=5.3 ps=40.53 pd=40.53
  XPM4 net013 Vbias_2 net010 vdd sky130_fd_pr__pfet_01v8_lvt W=20 L=0.7 nf=1 m=1 as=5.3 ad=5.3 ps=40.53 pd=40.53
  XPM5 vout Vbias_2 net016 vdd sky130_fd_pr__pfet_01v8_lvt W=20 L=0.7 nf=1 m=1 as=5.3 ad=5.3 ps=40.53 pd=40.53
  XPM1 net016 net013 vdd vdd sky130_fd_pr__pfet_01v8_lvt W=20 L=0.7 nf=1 m=1 as=5.3 ad=5.3 ps=40.53 pd=40.53
  XPM0 net016 net013 vdd vdd sky130_fd_pr__pfet_01v8_lvt W=20 L=0.7 nf=1 m=1 as=5.3 ad=5.3 ps=40.53 pd=40.53
.ends FC_Amp
.subckt ClassA_stg_PMOS Vbias_3 Vbias_4 vin vout
  XNM5 vout Vbias_3 net1 0 sky130_fd_pr__nfet_01v8_lvt W=5 L=0.3 nf=1 m=3 as=1.325 ad=1.325 ps=10.53 pd=10.53
  XNM4 net1 Vbias_4 0 0 sky130_fd_pr__nfet_01v8_lvt W=5 L=0.3 nf=1 m=3 as=1.325 ad=1.325 ps=10.53 pd=10.53
  XPM2 vout vin vdd vdd sky130_fd_pr__pfet_01v8_lvt W=20 L=0.7 nf=1 m=3 as=5.3 ad=5.3 ps=40.53 pd=40.53
.ends ClassA_stg_PMOS
.subckt Opamp_2stg_FC_ClassA Vbias_2 Vbias_3 Vbias_4 vm vout vp
  XI7 Vbias_2 Vbias_3 Vbias_4 vp net3 vm FC_Amp
  XI6 Vbias_3 Vbias_4 net3 vout ClassA_stg_PMOS
  CC1 net2 vout 4e-13 m=1
  RR1 net2 net3 3000 m=1
.ends Opamp_2stg_FC_ClassA
