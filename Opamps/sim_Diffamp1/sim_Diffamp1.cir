* sim_Diffamp1
* Converted from Cadence ADE Spectre (sky130_release_0.1.0 kit) by tools/spectre2ngspice.py
* MOSFETs: sky130A subcircuits, W/L in um from the meter-valued design parameters,
*   W per finger, nf=1, m = multiplier x fingers (as the Cadence pcell netlists it);
*   as/ad/ps/pd from the pcell geometry (cds_* functions below)
.lib "/opt/pdks/sky130A/libs.tech/ngspice/sky130.lib.spice" tt
* VCM: 0.5 in input.scs, 900m in the Spectre run (designParamVals) -> 900m used
* DESIGN CHANGE: Ln_MWS 2.7u -> 3.8u (Oct 9 2026: Cascode_bias retune (user approved). Ln_MWS 2.7u -> 3.8u raises Vbias3 about 50 mV (wide-swing bottom margin -11 -> +21 mV at tt), Lp_MWS 2.7u -> 3.4u lowers Vbias2 about 40 mV (PMOS bottom margin))
* DESIGN CHANGE: Lp_MWS 2.7u -> 3.4u (Oct 9 2026: Cascode_bias retune (user approved). Ln_MWS 2.7u -> 3.8u raises Vbias3 about 50 mV (wide-swing bottom margin -11 -> +21 mV at tt), Lp_MWS 2.7u -> 3.4u lowers Vbias2 about 40 mV (PMOS bottom margin))
* renamed (ngspice function names): Ln -> Ln_
.param pf=1 nf=1 Wn=5u Ln_=300n Ln_MWS=3.8u Wp=20u Lp=700n Lp_MWS=3.4u Ibias=20u VDD=1.8 VCM=900m
* Cadence sky130 pcell diffusion geometry (finger width w in meters, nf fingers);
* results in um^2 / um for the sky130A subcircuits (as/ad/ps/pd per finger, as Spectre had them)
.func cds_as(cdsw, cdsnf) {(((cdsw) < 289.5n) ? (((((175n > (((230n) - 60n) + 80n)) ? 175n : (((230n) - 60n) + 80n)) * 290n) + ((cdsw) * 75n)) + (floor(((cdsnf) - 1) / 2.0) * (((((230n) - 60n) + 80n) * 290n) + ((cdsw) * 150n))) + ((((cdsnf) / 2) - floor((cdsnf) / 2) == 0) ? ((((175n > (((230n) - 60n) + 80n)) ? 175n : (((230n) - 60n) + 80n)) * 290n) + ((cdsw) * 75n)) : 0)) / (cdsnf) : ((((250n > (((230n) - 60n) + 95n)) ? 250n : (((230n) - 60n) + 95n)) * (cdsw)) + (floor(((cdsnf) - 1) / 2.0) * ((((230n) - 60n) + 110n) * (cdsw))) + ((((cdsnf) / 2) - floor((cdsnf) / 2) == 0) ? (((250n > (((230n) - 60n) + 95n)) ? 250n : (((230n) - 60n) + 95n)) * (cdsw)) : 0)) / (cdsnf))*1e12}
.func cds_ad(cdsw, cdsnf) {(((cdsw) < 289.5n) ? ((floor((cdsnf) / 2.0) * (((((230n) - 60n) + 80n) * 290n) + ((cdsw) * 150n))) + ((((cdsnf) / 2) - floor((cdsnf) / 2) != 0) ? ((((175n > (((230n) - 60n) + 80n)) ? 175n : (((230n) - 60n) + 80n)) * 290n) + ((cdsw) * 75n)) : 0)) / (cdsnf) : ((floor((cdsnf) / 2.0) * ((((230n) - 60n) + 110n) * (cdsw))) + ((((cdsnf) / 2) - floor((cdsnf) / 2) != 0) ? (((250n > (((230n) - 60n) + 95n)) ? 250n : (((230n) - 60n) + 95n)) * (cdsw)) : 0)) / (cdsnf))*1e12}
.func cds_ps(cdsw, cdsnf) {(((cdsw) < 289.5n) ? (((2 * ((175n > (((230n) - 60n) + 80n)) ? 175n : (((230n) - 60n) + 80n))) + 730n) + (floor(((cdsnf) - 1) / 2.0) * ((2 * (((230n) - 60n) + 80n)) + 880n)) + ((((cdsnf) / 2) - floor((cdsnf) / 2) == 0) ? ((2 * ((175n > (((230n) - 60n) + 80n)) ? 175n : (((230n) - 60n) + 80n))) + 730n) : 0)) / (cdsnf) : (((2 * ((250n > (((230n) - 60n) + 95n)) ? 250n : (((230n) - 60n) + 95n))) + (2 * (cdsw))) + (floor(((cdsnf) - 1) / 2.0) * ((2 * (((230n) - 60n) + 110n)) + (2 * (cdsw)))) + ((((cdsnf) / 2) - floor((cdsnf) / 2) == 0) ? ((2 * ((250n > (((230n) - 60n) + 95n)) ? 250n : (((230n) - 60n) + 95n))) + (2 * (cdsw))) : 0)) / (cdsnf))*1e6}
.func cds_pd(cdsw, cdsnf) {(((cdsw) < 289.5n) ? ((floor((cdsnf) / 2.0) * ((2 * (((230n) - 60n) + 80n)) + 880n)) + ((((cdsnf) / 2) - floor((cdsnf) / 2) != 0) ? ((2 * ((175n > (((230n) - 60n) + 80n)) ? 175n : (((230n) - 60n) + 80n))) + 730n) : 0)) / (cdsnf) : ((floor((cdsnf) / 2.0) * ((2 * (((230n) - 60n) + 110n)) + (2 * (cdsw)))) + ((((cdsnf) / 2) - floor((cdsnf) / 2) != 0) ? ((2 * ((250n > (((230n) - 60n) + 95n)) ? 250n : (((230n) - 60n) + 95n))) + (2 * (cdsw))) : 0)) / (cdsnf))*1e6}
.global vdd
.options reltol=1e-3 gmin=1e-12 vntol=1e-6 abstol=1e-12 tnom=27
.temp 27

.subckt Cascode_bias Vbias_1 Vbias_2 Vbias_3 Vbias_4 Vbiasp
  XNM11 net4 net4 Vbias_4 0 sky130_fd_pr__nfet_01v8_lvt W={Wn*1e6} L={Ln_*1e6} nf=1 m=1 as={cds_as(Wn,1)} ad={cds_ad(Wn,1)} ps={cds_ps(Wn,1)} pd={cds_pd(Wn,1)}
  XNM9 net2 net2 Vbias_3 0 sky130_fd_pr__nfet_01v8_lvt W={Wn*1e6} L={Ln_*1e6} nf=1 m=1 as={cds_as(Wn,1)} ad={cds_ad(Wn,1)} ps={cds_ps(Wn,1)} pd={cds_pd(Wn,1)}
  XNM0 Vbias_3 Vbias_3 0 0 sky130_fd_pr__nfet_01v8_lvt W={Wn*1e6} L={Ln_MWS*1e6} nf=1 m=1 as={cds_as(Wn,1)} ad={cds_ad(Wn,1)} ps={cds_ps(Wn,1)} pd={cds_pd(Wn,1)}
  XNM6 net6 Vbias_4 0 0 sky130_fd_pr__nfet_01v8_lvt W={Wn*1e6} L={Ln_*1e6} nf=1 m=1 as={cds_as(Wn,1)} ad={cds_ad(Wn,1)} ps={cds_ps(Wn,1)} pd={cds_pd(Wn,1)}
  XNM4 net3 Vbias_4 0 0 sky130_fd_pr__nfet_01v8_lvt W={Wn*1e6} L={Ln_*1e6} nf=1 m=1 as={cds_as(Wn,1)} ad={cds_ad(Wn,1)} ps={cds_ps(Wn,1)} pd={cds_pd(Wn,1)}
  XNM2 net1 Vbias_4 0 0 sky130_fd_pr__nfet_01v8_lvt W={Wn*1e6} L={Ln_*1e6} nf=1 m=1 as={cds_as(Wn,1)} ad={cds_ad(Wn,1)} ps={cds_ps(Wn,1)} pd={cds_pd(Wn,1)}
  XNM5 Vbias_1 Vbias_3 net6 0 sky130_fd_pr__nfet_01v8_lvt W={Wn*1e6} L={Ln_*1e6} nf=1 m=1 as={cds_as(Wn,1)} ad={cds_ad(Wn,1)} ps={cds_ps(Wn,1)} pd={cds_pd(Wn,1)}
  XNM3 Vbias_2 Vbias_3 net3 0 sky130_fd_pr__nfet_01v8_lvt W={Wn*1e6} L={Ln_*1e6} nf=1 m=1 as={cds_as(Wn,1)} ad={cds_ad(Wn,1)} ps={cds_ps(Wn,1)} pd={cds_pd(Wn,1)}
  XNM1 Vbias_4 Vbias_3 net1 0 sky130_fd_pr__nfet_01v8_lvt W={Wn*1e6} L={Ln_*1e6} nf=1 m=1 as={cds_as(Wn,1)} ad={cds_ad(Wn,1)} ps={cds_ps(Wn,1)} pd={cds_pd(Wn,1)}
  XPM4 Vbias_1 Vbias_2 net5 vdd sky130_fd_pr__pfet_01v8_lvt W={Wp*1e6} L={Lp*1e6} nf=1 m=1 as={cds_as(Wp,1)} ad={cds_ad(Wp,1)} ps={cds_ps(Wp,1)} pd={cds_pd(Wp,1)}
  XPM3 net5 Vbias_1 vdd vdd sky130_fd_pr__pfet_01v8_lvt W={Wp*1e6} L={Lp*1e6} nf=1 m=1 as={cds_as(Wp,1)} ad={cds_ad(Wp,1)} ps={cds_ps(Wp,1)} pd={cds_pd(Wp,1)}
  XPM0 net2 Vbiasp vdd vdd sky130_fd_pr__pfet_01v8_lvt W={Wp*1e6} L={Lp*1e6} nf=1 m=1 as={cds_as(Wp,1)} ad={cds_ad(Wp,1)} ps={cds_ps(Wp,1)} pd={cds_pd(Wp,1)}
  XPM2 Vbias_2 Vbias_2 vdd vdd sky130_fd_pr__pfet_01v8_lvt W={Wp*1e6} L={Lp_MWS*1e6} nf=1 m=1 as={cds_as(Wp,1)} ad={cds_ad(Wp,1)} ps={cds_ps(Wp,1)} pd={cds_pd(Wp,1)}
  XPM1 net4 Vbiasp vdd vdd sky130_fd_pr__pfet_01v8_lvt W={Wp*1e6} L={Lp*1e6} nf=1 m=1 as={cds_as(Wp,1)} ad={cds_ad(Wp,1)} ps={cds_ps(Wp,1)} pd={cds_pd(Wp,1)}
.ends Cascode_bias
.subckt Diffamp1 Vbias_3 Vbias_4 vm vout vp
  XPM0 vout net9 vdd vdd sky130_fd_pr__pfet_01v8_lvt W={Wp*1e6} L={Lp*1e6} nf=1 m=1 as={cds_as(Wp,1)} ad={cds_ad(Wp,1)} ps={cds_ps(Wp,1)} pd={cds_pd(Wp,1)}
  XPM1 net9 net9 vdd vdd sky130_fd_pr__pfet_01v8_lvt W={Wp*1e6} L={Lp*1e6} nf=1 m=1 as={cds_as(Wp,1)} ad={cds_ad(Wp,1)} ps={cds_ps(Wp,1)} pd={cds_pd(Wp,1)}
  XNM1 vout vm net10 0 sky130_fd_pr__nfet_01v8_lvt W={Wn*1e6} L={Ln_*1e6} nf=1 m=1 as={cds_as(Wn,1)} ad={cds_ad(Wn,1)} ps={cds_ps(Wn,1)} pd={cds_pd(Wn,1)}
  XNM0 net9 vp net10 0 sky130_fd_pr__nfet_01v8_lvt W={Wn*1e6} L={Ln_*1e6} nf=1 m=1 as={cds_as(Wn,1)} ad={cds_ad(Wn,1)} ps={cds_ps(Wn,1)} pd={cds_pd(Wn,1)}
  XNM2 net10 Vbias_3 net12 0 sky130_fd_pr__nfet_01v8_lvt W={Wn*1e6} L={Ln_*1e6} nf=1 m=2 as={cds_as(Wn,2)} ad={cds_ad(Wn,2)} ps={cds_ps(Wn,2)} pd={cds_pd(Wn,2)}
  XNM3 net12 Vbias_4 0 0 sky130_fd_pr__nfet_01v8_lvt W={Wn*1e6} L={Ln_*1e6} nf=1 m=2 as={cds_as(Wn,2)} ad={cds_ad(Wn,2)} ps={cds_ps(Wn,2)} pd={cds_pd(Wn,2)}
.ends Diffamp1
.subckt Bias_gen Vbiasn Vbiasp
  XNM0 Vbiasn Vbiasn 0 0 sky130_fd_pr__nfet_01v8_lvt W={Wn*1e6} L={Ln_*1e6} nf=1 m=1 as={cds_as(Wn,1)} ad={cds_ad(Wn,1)} ps={cds_ps(Wn,1)} pd={cds_pd(Wn,1)}
  II1 Vbiasp 0 dc {Ibias}
  II0 vdd Vbiasn dc {Ibias}
  XPM0 Vbiasp Vbiasp vdd vdd sky130_fd_pr__pfet_01v8_lvt W={Wp*1e6} L={Lp*1e6} nf=1 m=1 as={cds_as(Wp,1)} ad={cds_ad(Wp,1)} ps={cds_ps(Wp,1)} pd={cds_pd(Wp,1)}
.ends Bias_gen
XI2 Vbias_1 Vbias_2 Vbias_3 Vbias_4 Vbiasp Cascode_bias
XI1 Vbias_3 Vbias_4 net5 vout net03 Diffamp1
VV3 vdd 0 dc {VDD}
VV0 net5 0 dc {VCM}
VV2 net03 net5 dc 0 ac 1
CC0 vout 0 1p m=1
XI0 Vbiasn Vbiasp Bias_gen

.control
set wr_singlescale
set wr_vecnames
option numdgt=7
op
show m : id vgs vds vth vdsat gm gds
print all > op_nodes.txt
show m : id vgs vds vth vdsat gm gds cgs cgd > op_devices.txt
ac dec 50 10 1G
wrdata ac.txt all
let vout_db = db(v(vout))
let vout_ph = 180/pi*cph(v(vout))
meas ac vout_gain_db find vout_db at=10
meas ac vout_ugf when vout_db=0
meas ac vout_ph_ugf find vout_ph at=vout_ugf
print vout_gain_db vout_ugf vout_ph_ugf > ac_meas.txt
.endc
.end
