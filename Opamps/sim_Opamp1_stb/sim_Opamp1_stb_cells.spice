* sim_Opamp1_stb: subcircuits with parameters evaluated (W/L in um, sky130A models)
* generated by tools/import_cadence.py from sim_Opamp1_stb.cir
.subckt Bias_gen Vbiasn Vbiasp
  XNM0 Vbiasn Vbiasn 0 0 sky130_fd_pr__nfet_01v8_lvt W=5 L=0.3 nf=1 m=1 as=1.325 ad=1.325 ps=10.53 pd=10.53
  II1 Vbiasp 0 dc 2e-05
  II0 vdd Vbiasn dc 2e-05
  XPM0 Vbiasp Vbiasp vdd vdd sky130_fd_pr__pfet_01v8_lvt W=20 L=0.7 nf=1 m=1 as=5.3 ad=5.3 ps=40.53 pd=40.53
.ends Bias_gen
.subckt Cascode_bias Vbias_1 Vbias_2 Vbias_3 Vbias_4 Vbiasp
  XNM11 net4 net4 Vbias_4 0 sky130_fd_pr__nfet_01v8_lvt W=5 L=0.3 nf=1 m=1 as=1.325 ad=1.325 ps=10.53 pd=10.53
  XNM9 net2 net2 Vbias_3 0 sky130_fd_pr__nfet_01v8_lvt W=5 L=0.3 nf=1 m=1 as=1.325 ad=1.325 ps=10.53 pd=10.53
  XNM0 Vbias_3 Vbias_3 0 0 sky130_fd_pr__nfet_01v8_lvt W=5 L=3.8 nf=1 m=1 as=1.325 ad=1.325 ps=10.53 pd=10.53
  XNM6 net6 Vbias_4 0 0 sky130_fd_pr__nfet_01v8_lvt W=5 L=0.3 nf=1 m=1 as=1.325 ad=1.325 ps=10.53 pd=10.53
  XNM4 net3 Vbias_4 0 0 sky130_fd_pr__nfet_01v8_lvt W=5 L=0.3 nf=1 m=1 as=1.325 ad=1.325 ps=10.53 pd=10.53
  XNM2 net1 Vbias_4 0 0 sky130_fd_pr__nfet_01v8_lvt W=5 L=0.3 nf=1 m=1 as=1.325 ad=1.325 ps=10.53 pd=10.53
  XNM5 Vbias_1 Vbias_3 net6 0 sky130_fd_pr__nfet_01v8_lvt W=5 L=0.3 nf=1 m=1 as=1.325 ad=1.325 ps=10.53 pd=10.53
  XNM3 Vbias_2 Vbias_3 net3 0 sky130_fd_pr__nfet_01v8_lvt W=5 L=0.3 nf=1 m=1 as=1.325 ad=1.325 ps=10.53 pd=10.53
  XNM1 Vbias_4 Vbias_3 net1 0 sky130_fd_pr__nfet_01v8_lvt W=5 L=0.3 nf=1 m=1 as=1.325 ad=1.325 ps=10.53 pd=10.53
  XPM4 Vbias_1 Vbias_2 net5 vdd sky130_fd_pr__pfet_01v8_lvt W=20 L=0.7 nf=1 m=1 as=5.3 ad=5.3 ps=40.53 pd=40.53
  XPM3 net5 Vbias_1 vdd vdd sky130_fd_pr__pfet_01v8_lvt W=20 L=0.7 nf=1 m=1 as=5.3 ad=5.3 ps=40.53 pd=40.53
  XPM0 net2 Vbiasp vdd vdd sky130_fd_pr__pfet_01v8_lvt W=20 L=0.7 nf=1 m=1 as=5.3 ad=5.3 ps=40.53 pd=40.53
  XPM2 Vbias_2 Vbias_2 vdd vdd sky130_fd_pr__pfet_01v8_lvt W=20 L=3.4 nf=1 m=1 as=5.3 ad=5.3 ps=40.53 pd=40.53
  XPM1 net4 Vbiasp vdd vdd sky130_fd_pr__pfet_01v8_lvt W=20 L=0.7 nf=1 m=1 as=5.3 ad=5.3 ps=40.53 pd=40.53
.ends Cascode_bias
.subckt Opamp1 Vbias_3 Vbias_4 vm vout vp
  CC0 net012 vout 6e-13 m=1
  RR0 net08 net012 3000 m=1
  XNM1 net08 vp net1 0 sky130_fd_pr__nfet_01v8_lvt W=5 L=0.3 nf=1 m=1 as=1.325 ad=1.325 ps=10.53 pd=10.53
  XNM0 net3 vm net1 0 sky130_fd_pr__nfet_01v8_lvt W=5 L=0.3 nf=1 m=1 as=1.325 ad=1.325 ps=10.53 pd=10.53
  XNM2 net1 Vbias_3 net2 0 sky130_fd_pr__nfet_01v8_lvt W=5 L=0.3 nf=1 m=2 as=1.325 ad=0.7 ps=10.53 pd=5.28
  XNM3 net2 Vbias_4 0 0 sky130_fd_pr__nfet_01v8_lvt W=5 L=0.3 nf=1 m=2 as=1.325 ad=0.7 ps=10.53 pd=5.28
  XNM4 net010 Vbias_4 0 0 sky130_fd_pr__nfet_01v8_lvt W=5 L=0.3 nf=1 m=6 as=1.325 ad=0.7 ps=10.53 pd=5.28
  XNM5 vout Vbias_3 net010 0 sky130_fd_pr__nfet_01v8_lvt W=5 L=0.3 nf=1 m=6 as=1.325 ad=0.7 ps=10.53 pd=5.28
  XPM0 net08 net3 vdd vdd sky130_fd_pr__pfet_01v8_lvt W=20 L=0.7 nf=1 m=1 as=5.3 ad=5.3 ps=40.53 pd=40.53
  XPM1 net3 net3 vdd vdd sky130_fd_pr__pfet_01v8_lvt W=20 L=0.7 nf=1 m=1 as=5.3 ad=5.3 ps=40.53 pd=40.53
  XPM2 vout net08 vdd vdd sky130_fd_pr__pfet_01v8_lvt W=20 L=0.7 nf=1 m=3 as=5.3 ad=5.3 ps=40.53 pd=40.53
.ends Opamp1
