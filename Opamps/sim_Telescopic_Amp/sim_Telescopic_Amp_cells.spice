* sim_Telescopic_Amp: subcircuits with parameters evaluated (W/L in um, sky130A models)
* generated by tools/import_cadence.py from sim_Telescopic_Amp.cir
.subckt Telescopic_Amp VCM Vbias_2 Vbias_3 Vbias_4 vm vout vp
  XPM2 net0100 net082 vdd vdd sky130_fd_pr__pfet_01v8_lvt W=20 L=0.7 nf=1 m=1 as=5.3 ad=5.3 ps=40.53 pd=40.53
  XPM3 net097 net082 vdd vdd sky130_fd_pr__pfet_01v8_lvt W=20 L=0.7 nf=1 m=1 as=5.3 ad=5.3 ps=40.53 pd=40.53
  XPM4 net016 Vbias5 vdd vdd sky130_fd_pr__pfet_01v8_lvt W=4 L=0.7 nf=1 m=1 as=1.06 ad=1.06 ps=8.53 pd=8.53
  XPM1 net082 Vbias_2 net0100 vdd sky130_fd_pr__pfet_01v8_lvt W=20 L=0.7 nf=1 m=1 as=5.3 ad=5.3 ps=40.53 pd=40.53
  XPM0 vout Vbias_2 net097 vdd sky130_fd_pr__pfet_01v8_lvt W=20 L=0.7 nf=1 m=1 as=5.3 ad=5.3 ps=40.53 pd=40.53
  XPM5 Vbias5 Vbias_2 net016 vdd sky130_fd_pr__pfet_01v8_lvt W=4 L=0.7 nf=1 m=1 as=1.06 ad=1.06 ps=8.53 pd=8.53
  XNM8 Vbias5 Vbias5 net015 0 sky130_fd_pr__nfet_01v8_lvt W=1 L=0.3 nf=1 m=1 as=0.265 ad=0.265 ps=2.53 pd=2.53
  XNM9 net015 VCM net014 0 sky130_fd_pr__nfet_01v8_lvt W=1 L=0.3 nf=1 m=1 as=0.265 ad=0.265 ps=2.53 pd=2.53
  XNM4 net8 Vbias_3 net012 0 sky130_fd_pr__nfet_01v8_lvt W=5 L=0.3 nf=1 m=1 as=1.325 ad=1.325 ps=10.53 pd=10.53
  XNM6 net012 Vbias_4 0 0 sky130_fd_pr__nfet_01v8_lvt W=5 L=0.3 nf=1 m=1 as=1.325 ad=1.325 ps=10.53 pd=10.53
  XNM10 net014 Vbias_3 net017 0 sky130_fd_pr__nfet_01v8_lvt W=1 L=0.3 nf=1 m=1 as=0.265 ad=0.265 ps=2.53 pd=2.53
  XNM1 net030 vm net8 0 sky130_fd_pr__nfet_01v8_lvt W=5 L=0.3 nf=1 m=1 as=1.325 ad=1.325 ps=10.53 pd=10.53
  XNM7 net6 Vbias_4 0 0 sky130_fd_pr__nfet_01v8_lvt W=5 L=0.3 nf=1 m=1 as=1.325 ad=1.325 ps=10.53 pd=10.53
  XNM0 net074 vp net8 0 sky130_fd_pr__nfet_01v8_lvt W=5 L=0.3 nf=1 m=1 as=1.325 ad=1.325 ps=10.53 pd=10.53
  XNM5 net8 Vbias_3 net6 0 sky130_fd_pr__nfet_01v8_lvt W=5 L=0.3 nf=1 m=1 as=1.325 ad=1.325 ps=10.53 pd=10.53
  XNM3 vout Vbias5 net030 0 sky130_fd_pr__nfet_01v8_lvt W=5 L=0.3 nf=1 m=1 as=1.325 ad=1.325 ps=10.53 pd=10.53
  XNM2 net082 Vbias5 net074 0 sky130_fd_pr__nfet_01v8_lvt W=5 L=0.3 nf=1 m=1 as=1.325 ad=1.325 ps=10.53 pd=10.53
  XNM11 net017 Vbias_4 0 0 sky130_fd_pr__nfet_01v8_lvt W=1 L=0.3 nf=1 m=1 as=0.265 ad=0.265 ps=2.53 pd=2.53
.ends Telescopic_Amp
.subckt Cascode_bias Vbias_1 Vbias_2 Vbias_3 Vbias_4 Vbiasp
  XNM11 net4 net4 Vbias_4 0 sky130_fd_pr__nfet_01v8_lvt W=5 L=0.3 nf=1 m=1 as=1.325 ad=1.325 ps=10.53 pd=10.53
  XNM9 net2 net2 Vbias_3 0 sky130_fd_pr__nfet_01v8_lvt W=5 L=0.3 nf=1 m=1 as=1.325 ad=1.325 ps=10.53 pd=10.53
  XNM0 Vbias_3 Vbias_3 0 0 sky130_fd_pr__nfet_01v8_lvt W=5 L=3.8 nf=1 m=1 as=1.325 ad=1.325 ps=10.53 pd=10.53
  XNM6 net6 Vbias_4 0 0 sky130_fd_pr__nfet_01v8_lvt W=5 L=0.3 nf=1 m=1 as=1.325 ad=1.325 ps=10.53 pd=10.53
  XNM4 net3 Vbias_4 0 0 sky130_fd_pr__nfet_01v8_lvt W=5 L=0.3 nf=1 m=1 as=1.325 ad=1.325 ps=10.53 pd=10.53
  XNM2 net1 Vbias_4 0 0 sky130_fd_pr__nfet_01v8_lvt W=5 L=0.3 nf=1 m=1 as=1.325 ad=1.325 ps=10.53 pd=10.53
  XNM5 Vbias_1 Vbias_3 net6 0 sky130_fd_pr__nfet_01v8_lvt W=5 L=0.3 nf=1 m=1 as=1.325 ad=1.325 ps=10.53 pd=10.53
  XNM3 Vbias_2 Vbias_3 net3 0 sky130_fd_pr__nfet_01v8_lvt W=5 L=0.3 nf=1 m=1 as=1.325 ad=1.325 ps=10.53 pd=10.53
  XNM1 Vbias_4 Vbias_3 net1 0 sky130_fd_pr__nfet_01v8_lvt W=5 L=0.3 nf=1 m=1 as=1.325 ad=1.325 ps=10.53 pd=10.53
  XPM4 Vbias_1 Vbias_2 net5 vdd sky130_fd_pr__pfet_01v8_lvt W=20 L=0.7 nf=1 m=1 as=5.3 ad=5.3 ps=40.53 pd=40.53
  XPM3 net5 Vbias_1 vdd vdd sky130_fd_pr__pfet_01v8_lvt W=20 L=0.7 nf=1 m=1 as=5.3 ad=5.3 ps=40.53 pd=40.53
  XPM0 net2 Vbiasp vdd vdd sky130_fd_pr__pfet_01v8_lvt W=20 L=0.7 nf=1 m=1 as=5.3 ad=5.3 ps=40.53 pd=40.53
  XPM2 Vbias_2 Vbias_2 vdd vdd sky130_fd_pr__pfet_01v8_lvt W=20 L=3.4 nf=1 m=1 as=5.3 ad=5.3 ps=40.53 pd=40.53
  XPM1 net4 Vbiasp vdd vdd sky130_fd_pr__pfet_01v8_lvt W=20 L=0.7 nf=1 m=1 as=5.3 ad=5.3 ps=40.53 pd=40.53
.ends Cascode_bias
.subckt Bias_gen Vbiasn Vbiasp
  XNM0 Vbiasn Vbiasn 0 0 sky130_fd_pr__nfet_01v8_lvt W=5 L=0.3 nf=1 m=1 as=1.325 ad=1.325 ps=10.53 pd=10.53
  II1 Vbiasp 0 dc 2e-05
  II0 vdd Vbiasn dc 2e-05
  XPM0 Vbiasp Vbiasp vdd vdd sky130_fd_pr__pfet_01v8_lvt W=20 L=0.7 nf=1 m=1 as=5.3 ad=5.3 ps=40.53 pd=40.53
.ends Bias_gen
