* nmos_char
* Converted from Cadence ADE Spectre (sky130_release_0.1.0 kit) by tools/spectre2ngspice.py
* MOSFETs: sky130A subcircuits, W/L in um from the meter-valued design parameters,
*   W per finger, nf=1, m = multiplier x fingers (as the Cadence pcell netlists it);
*   as/ad/ps/pd from the pcell geometry (cds_* functions below)
.lib "/opt/pdks/sky130A/libs.tech/ngspice/sky130.lib.spice" tt
* L: 500n in input.scs, 300n in the Spectre run (designParamVals) -> 300n used
.param Wn=5u L=300n VGS=630m VDS=1
* Cadence sky130 pcell diffusion geometry (finger width w in meters, nf fingers);
* results in um^2 / um for the sky130A subcircuits (as/ad/ps/pd per finger, as Spectre had them)
.func cds_as(cdsw, cdsnf) {(((cdsw) < 289.5n) ? (((((175n > (((230n) - 60n) + 80n)) ? 175n : (((230n) - 60n) + 80n)) * 290n) + ((cdsw) * 75n)) + (floor(((cdsnf) - 1) / 2.0) * (((((230n) - 60n) + 80n) * 290n) + ((cdsw) * 150n))) + ((((cdsnf) / 2) - floor((cdsnf) / 2) == 0) ? ((((175n > (((230n) - 60n) + 80n)) ? 175n : (((230n) - 60n) + 80n)) * 290n) + ((cdsw) * 75n)) : 0)) / (cdsnf) : ((((250n > (((230n) - 60n) + 95n)) ? 250n : (((230n) - 60n) + 95n)) * (cdsw)) + (floor(((cdsnf) - 1) / 2.0) * ((((230n) - 60n) + 110n) * (cdsw))) + ((((cdsnf) / 2) - floor((cdsnf) / 2) == 0) ? (((250n > (((230n) - 60n) + 95n)) ? 250n : (((230n) - 60n) + 95n)) * (cdsw)) : 0)) / (cdsnf))*1e12}
.func cds_ad(cdsw, cdsnf) {(((cdsw) < 289.5n) ? ((floor((cdsnf) / 2.0) * (((((230n) - 60n) + 80n) * 290n) + ((cdsw) * 150n))) + ((((cdsnf) / 2) - floor((cdsnf) / 2) != 0) ? ((((175n > (((230n) - 60n) + 80n)) ? 175n : (((230n) - 60n) + 80n)) * 290n) + ((cdsw) * 75n)) : 0)) / (cdsnf) : ((floor((cdsnf) / 2.0) * ((((230n) - 60n) + 110n) * (cdsw))) + ((((cdsnf) / 2) - floor((cdsnf) / 2) != 0) ? (((250n > (((230n) - 60n) + 95n)) ? 250n : (((230n) - 60n) + 95n)) * (cdsw)) : 0)) / (cdsnf))*1e12}
.func cds_ps(cdsw, cdsnf) {(((cdsw) < 289.5n) ? (((2 * ((175n > (((230n) - 60n) + 80n)) ? 175n : (((230n) - 60n) + 80n))) + 730n) + (floor(((cdsnf) - 1) / 2.0) * ((2 * (((230n) - 60n) + 80n)) + 880n)) + ((((cdsnf) / 2) - floor((cdsnf) / 2) == 0) ? ((2 * ((175n > (((230n) - 60n) + 80n)) ? 175n : (((230n) - 60n) + 80n))) + 730n) : 0)) / (cdsnf) : (((2 * ((250n > (((230n) - 60n) + 95n)) ? 250n : (((230n) - 60n) + 95n))) + (2 * (cdsw))) + (floor(((cdsnf) - 1) / 2.0) * ((2 * (((230n) - 60n) + 110n)) + (2 * (cdsw)))) + ((((cdsnf) / 2) - floor((cdsnf) / 2) == 0) ? ((2 * ((250n > (((230n) - 60n) + 95n)) ? 250n : (((230n) - 60n) + 95n))) + (2 * (cdsw))) : 0)) / (cdsnf))*1e6}
.func cds_pd(cdsw, cdsnf) {(((cdsw) < 289.5n) ? ((floor((cdsnf) / 2.0) * ((2 * (((230n) - 60n) + 80n)) + 880n)) + ((((cdsnf) / 2) - floor((cdsnf) / 2) != 0) ? ((2 * ((175n > (((230n) - 60n) + 80n)) ? 175n : (((230n) - 60n) + 80n))) + 730n) : 0)) / (cdsnf) : ((floor((cdsnf) / 2.0) * ((2 * (((230n) - 60n) + 110n)) + (2 * (cdsw)))) + ((((cdsnf) / 2) - floor((cdsnf) / 2) != 0) ? ((2 * ((250n > (((230n) - 60n) + 95n)) ? 250n : (((230n) - 60n) + 95n))) + (2 * (cdsw))) : 0)) / (cdsnf))*1e6}
.options reltol=1e-3 gmin=1e-12 vntol=1e-6 abstol=1e-12 tnom=27
.temp 27.0

VV1 VDS 0 dc {VDS}
VV0 VGS 0 dc {VGS}
XNM0 VDS VGS 0 0 sky130_fd_pr__nfet_01v8_lvt W={Wn*1e6} L={L*1e6} nf=1 m=1 as={cds_as(Wn,1)} ad={cds_ad(Wn,1)} ps={cds_ps(Wn,1)} pd={cds_pd(Wn,1)}

.control
set wr_singlescale
set wr_vecnames
option numdgt=7
save all @m.xnm0.msky130_fd_pr__nfet_01v8_lvt[id]
op
show m : id vgs vds vth vdsat gm gds
print all > op_nodes.txt
show m : id vgs vds vth vdsat gm gds cgs cgd > op_devices.txt
dc VV1 0 1.8 0.036
wrdata dc_sweep.txt all
.endc
.end
