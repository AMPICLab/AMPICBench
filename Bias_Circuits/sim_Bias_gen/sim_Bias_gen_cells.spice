* sim_Bias_gen: subcircuits with parameters evaluated (W/L in um, sky130A models)
* generated by tools/import_cadence.py from sim_Bias_gen.cir
.subckt Bias_gen Vbiasn Vbiasp
  XNM0 Vbiasn Vbiasn 0 0 sky130_fd_pr__nfet_01v8_lvt W=5 L=0.3 nf=1 m=1 as=1.325 ad=1.325 ps=10.53 pd=10.53
  II1 Vbiasp 0 dc 2e-05
  II0 vdd Vbiasn dc 2e-05
  XPM0 Vbiasp Vbiasp vdd vdd sky130_fd_pr__pfet_01v8_lvt W=20 L=0.35 nf=1 m=1 as=5.3 ad=5.3 ps=40.53 pd=40.53
.ends Bias_gen
